* bjt_current_mirror  (own)
VCC 1 0 DC 15
Iref 1 2 DC 1m
Q1 2 2 0 QN
Q2 3 2 0 QN
RL 1 3 5k
.model QN NPN(Is=1e-15 Vt=0.02585 betaF=100 betaR=1)
.end
