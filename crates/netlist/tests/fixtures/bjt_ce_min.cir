* bjt_ce_min  (Kuphaldt SEMI_4, DSL)
Vbias 5 0 DC 2.3
Vin 1 5 AC 1.5
R1 1 2 1k
Q1 3 2 0 QN
Rspkr 3 4 8
V1 4 0 DC 15
.model QN NPN(Is=1e-15 Vt=0.02585 betaF=100 betaR=1)
.end
