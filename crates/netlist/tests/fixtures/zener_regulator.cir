* zener_regulator  5.6V shunt regulator (diode reverse breakdown, BV)
V1 in 0 9
R1 in out 470
D1 0 out ZD
.model ZD D(Is=1e-14 N=1 BV=5.6 IBV=5m)
.end
