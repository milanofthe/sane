// Standard Verilog-AMS mathematical and physical constants (Accellera LRM
// Annex B names). Provided as a built-in header so `\`include "constants.vams"`
// resolves without an external file.
//
// The physical values follow the 2019 exact-SI redefinition (CODATA 2018),
// matching `sane_core::constants` -- ONE engine-wide constant set, shared by
// the built-in device models, `$vt`, and the Rust side. (LRM Annex B predates
// the redefinition and lists the older CODATA values; SANE deliberately uses
// the current exact ones everywhere.)
`ifdef CONSTANTS_VAMS
`else
`define CONSTANTS_VAMS 1

`define M_E         2.7182818284590452354
`define M_LOG2E     1.4426950408889634074
`define M_LOG10E    0.43429448190325182765
`define M_LN2       0.69314718055994530942
`define M_LN10      2.30258509299404568402
`define M_PI        3.14159265358979323846
`define M_TWO_PI    6.28318530717958647693
`define M_PI_2      1.57079632679489661923
`define M_PI_4      0.78539816339744830962
`define M_1_PI      0.31830988618379067154
`define M_2_PI      0.63661977236758134308
`define M_2_SQRTPI  1.12837916709551257390
`define M_SQRT2     1.41421356237309504880
`define M_SQRT1_2   0.70710678118654752440

`define P_Q         1.602176634e-19
`define P_C         2.99792458e8
`define P_K         1.380649e-23
`define P_H         6.62607015e-34
`define P_EPS0      8.8541878128e-12
`define P_U0        1.25663706212e-6
`define P_CELSIUS0  273.15

`endif
