* biased_clipper  (Kuphaldt SEMI_3, DSL)
V1 3 0 DC 1.3
V2 4 0 DC -2.3
V3 1 0 AC 5
R1 2 1 1k
D1 2 3 DMOD
D2 4 2 DMOD
.model DMOD D(Is=1e-14 N=1 Vt=0.02585)
.end
