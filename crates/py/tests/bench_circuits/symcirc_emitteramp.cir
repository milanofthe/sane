* imported from symcirc/test_circuits/Emitteramp_deutsch.net (github.com/Creapson/symcirc)
* Schematics Netlist +

Q_Q1         4 3 5 Q2N2222
Vcc         6 0 DC 15
Cin         1 3 100n
R1         6 3 95331.9
R2         3 0 25683.2
RC         6 4 3947.37
RL         2 0 1000k
Cout         4 2 10n
RE         5 0 1198.02
VIN         1 0  AC 1 sin( 0 0.1 1000hz )

.model Q2N2222
+ NPN
+ IS=14.340000E-15
+ BF=255.9
+ NF=1
+ VAF=74.03
+ IKF=.2847
+ ISE=14.340000E-15
+ NE=1.307
+ BR=6.092
+ NR=1
+ RB=10
+ RC=1
+ CJE=22.010000E-12
+ MJE=.377
+ CJC=7.306000E-12
+ MJC=.3416
+ TF=411.100000E-12
+ XTF=3
+ VTF=1.7
+ ITF=.6
+ TR=46.910000E-09
+ XTB=1.5
.end
