* parallel_tank  (Kuphaldt, DSL)
* https://www.ibiblio.org/kuphaldt/electricCircuits/AC/AC_6.html
V1 1 0 AC 1
C1 1 0 10u
L1 1 0 100m
.end
